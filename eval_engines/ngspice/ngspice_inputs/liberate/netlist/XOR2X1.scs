// Design: CNT_CMOS/XOR2X1
simulator lang=spectre
//global 0 VDD VSS
//include "/simulation/tianliang/test/gpdk045_v_6_0/gpdk045/../models/spectre/gpdk045.scs" section=mc

// CNT_CMOS/XOR2X1/schematic
subckt XOR2X1 VSS VDD A B Y
mp4 (n1 B n0) CNT_CDF l=0.6 w=5 MU=55 COX=150e-09 COL=0 CGSD=0 COLGSD=0 CSD=0 VTO=-0.7 FLG_SPLT=1 FINGER=1 sdW=10 gsdEnc=1 gcntEnc=3 TEMP=300 LAMBDA=0.005 VSS=0.074 GAMMA=0.35 IOFF=0 MM=1.65 AA=1 SLOPE=10 VAA=1 RCS=1450 RCD=1450 FLG_FLD=0 RFS=1 RFD=1 RFG=1 typep=-1
mp2 (net26 n1 VDD) CNT_CDF l=0.6 w=5 MU=55 COX=150e-09 COL=0 CGSD=0 COLGSD=0 CSD=0 VTO=-0.7 FLG_SPLT=1 FINGER=1 sdW=10 gsdEnc=1 gcntEnc=3 TEMP=300 LAMBDA=0.005 VSS=0.074 GAMMA=0.35 IOFF=0 MM=1.65 AA=1 SLOPE=10 VAA=1 RCS=1450 RCD=1450 FLG_FLD=0 RFS=1 RFD=1 RFG=1 typep=-1
mp1 (n2 B VDD) CNT_CDF l=0.6 w=5 MU=55 COX=150e-09 COL=0 CGSD=0 COLGSD=0 CSD=0 VTO=-0.7 FLG_SPLT=1 FINGER=1 sdW=10 gsdEnc=1 gcntEnc=3 TEMP=300 LAMBDA=0.005 VSS=0.074 GAMMA=0.35 IOFF=0 MM=1.65 AA=1 SLOPE=10 VAA=1 RCS=1450 RCD=1450 FLG_FLD=0 RFS=1 RFD=1 RFG=1 typep=-1
mp0 (n1 A VDD) CNT_CDF l=0.6 w=5 MU=55 COX=150e-09 COL=0 CGSD=0 COLGSD=0 CSD=0 VTO=-0.7 FLG_SPLT=1 FINGER=1 sdW=10 gsdEnc=1 gcntEnc=3 TEMP=300 LAMBDA=0.005 VSS=0.074 GAMMA=0.35 IOFF=0 MM=1.65 AA=1 SLOPE=10 VAA=1 RCS=1450 RCD=1450 FLG_FLD=0 RFS=1 RFD=1 RFG=1 typep=-1
mp5 (Y n0 VDD) CNT_CDF l=0.6 w=5 MU=55 COX=150e-09 COL=0 CGSD=0 COLGSD=0 CSD=0 VTO=-0.7 FLG_SPLT=1 FINGER=1 sdW=10 gsdEnc=1 gcntEnc=3 TEMP=300 LAMBDA=0.005 VSS=0.074 GAMMA=0.35 IOFF=0 MM=1.65 AA=1 SLOPE=10 VAA=1 RCS=1450 RCD=1450 FLG_FLD=0 RFS=1 RFD=1 RFG=1 typep=-1
mp3 (n0 n2 net26) CNT_CDF l=0.6 w=5 MU=55 COX=150e-09 COL=0 CGSD=0 COLGSD=0 CSD=0 VTO=-0.7 FLG_SPLT=1 FINGER=1 sdW=10 gsdEnc=1 gcntEnc=3 TEMP=300 LAMBDA=0.005 VSS=0.074 GAMMA=0.35 IOFF=0 MM=1.65 AA=1 SLOPE=10 VAA=1 RCS=1450 RCD=1450 FLG_FLD=0 RFS=1 RFD=1 RFG=1 typep=-1
mn3 (net27 B n0) CNT_CDF_N l=0.6 w=5 MU=55 COX=150e-09 COL=0 CGSD=0 COLGSD=0 CSD=0 VTO=0.7 FLG_SPLT=1 FINGER=1 sdW=10 gsdEnc=1 gcntEnc=3 TEMP=300 LAMBDA=0.005 VSS=0.074 GAMMA=0.35 IOFF=0 MM=1.65 AA=1 SLOPE=10 VAA=1 RCS=1450 RCD=1450 FLG_FLD=0 RFS=1 RFD=1 RFG=1 typep=1
mn4 (n1 n2 n0) CNT_CDF_N l=0.6 w=5 MU=55 COX=150e-09 COL=0 CGSD=0 COLGSD=0 CSD=0 VTO=0.7 FLG_SPLT=1 FINGER=1 sdW=10 gsdEnc=1 gcntEnc=3 TEMP=300 LAMBDA=0.005 VSS=0.074 GAMMA=0.35 IOFF=0 MM=1.65 AA=1 SLOPE=10 VAA=1 RCS=1450 RCD=1450 FLG_FLD=0 RFS=1 RFD=1 RFG=1 typep=1
mn1 (VSS B n2) CNT_CDF_N l=0.6 w=5 MU=55 COX=150e-09 COL=0 CGSD=0 COLGSD=0 CSD=0 VTO=0.7 FLG_SPLT=1 FINGER=1 sdW=10 gsdEnc=1 gcntEnc=3 TEMP=300 LAMBDA=0.005 VSS=0.074 GAMMA=0.35 IOFF=0 MM=1.65 AA=1 SLOPE=10 VAA=1 RCS=1450 RCD=1450 FLG_FLD=0 RFS=1 RFD=1 RFG=1 typep=1
mn0 (VSS A n1) CNT_CDF_N l=0.6 w=5 MU=55 COX=150e-09 COL=0 CGSD=0 COLGSD=0 CSD=0 VTO=0.7 FLG_SPLT=1 FINGER=1 sdW=10 gsdEnc=1 gcntEnc=3 TEMP=300 LAMBDA=0.005 VSS=0.074 GAMMA=0.35 IOFF=0 MM=1.65 AA=1 SLOPE=10 VAA=1 RCS=1450 RCD=1450 FLG_FLD=0 RFS=1 RFD=1 RFG=1 typep=1
mn5 (VSS n0 Y) CNT_CDF_N l=0.6 w=5 MU=55 COX=150e-09 COL=0 CGSD=0 COLGSD=0 CSD=0 VTO=0.7 FLG_SPLT=1 FINGER=1 sdW=10 gsdEnc=1 gcntEnc=3 TEMP=300 LAMBDA=0.005 VSS=0.074 GAMMA=0.35 IOFF=0 MM=1.65 AA=1 SLOPE=10 VAA=1 RCS=1450 RCD=1450 FLG_FLD=0 RFS=1 RFD=1 RFG=1 typep=1
mn2 (VSS n1 net27) CNT_CDF_N l=0.6 w=5 MU=55 COX=150e-09 COL=0 CGSD=0 COLGSD=0 CSD=0 VTO=0.7 FLG_SPLT=1 FINGER=1 sdW=10 gsdEnc=1 gcntEnc=3 TEMP=300 LAMBDA=0.005 VSS=0.074 GAMMA=0.35 IOFF=0 MM=1.65 AA=1 SLOPE=10 VAA=1 RCS=1450 RCD=1450 FLG_FLD=0 RFS=1 RFD=1 RFG=1 typep=1
ends XOR2X1
