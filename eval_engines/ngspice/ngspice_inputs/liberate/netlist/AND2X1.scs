// Design: CNT_CMOS/AND2X1
simulator lang=spectre
//global 0 VDD VSS
//include "/simulation/tianliang/test/gpdk045_v_6_0/gpdk045/../models/spectre/gpdk045.scs" section=mc

// CNT_CMOS/AND2X1/schematic
subckt AND2X1 A B Y
mp1 (n0 B VDD) CNT_CDF l=0.6 w=5 MU=55 COX=150e-09 COL=0 CGSD=0 COLGSD=0 CSD=0 VTO=-0.7 FLG_SPLT=1 FINGER=1 sdW=10 gsdEnc=1 gcntEnc=3 TEMP=300 LAMBDA=0.005 VSS=0.074 GAMMA=0.35 IOFF=0 MM=1.65 AA=1 SLOPE=10 VAA=1 RCS=1450 RCD=1450 FLG_FLD=0 RFS=1 RFD=1 RFG=1 typep=-1
mp2 (Y n0 VDD) CNT_CDF l=0.6 w=5 MU=55 COX=150e-09 COL=0 CGSD=0 COLGSD=0 CSD=0 VTO=-0.7 FLG_SPLT=1 FINGER=1 sdW=10 gsdEnc=1 gcntEnc=3 TEMP=300 LAMBDA=0.005 VSS=0.074 GAMMA=0.35 IOFF=0 MM=1.65 AA=1 SLOPE=10 VAA=1 RCS=1450 RCD=1450 FLG_FLD=0 RFS=1 RFD=1 RFG=1 typep=-1
mp0 (n0 A VDD) CNT_CDF l=0.6 w=5 MU=55 COX=150e-09 COL=0 CGSD=0 COLGSD=0 CSD=0 VTO=-0.7 FLG_SPLT=1 FINGER=1 sdW=10 gsdEnc=1 gcntEnc=3 TEMP=300 LAMBDA=0.005 VSS=0.074 GAMMA=0.35 IOFF=0 MM=1.65 AA=1 SLOPE=10 VAA=1 RCS=1450 RCD=1450 FLG_FLD=0 RFS=1 RFD=1 RFG=1 typep=-1
mn1 (net6 A n0) CNT_CDF_N l=0.6 w=5 MU=55 COX=150e-09 COL=0 CGSD=0 COLGSD=0 CSD=0 VTO=0.7 FLG_SPLT=1 FINGER=1 sdW=10 gsdEnc=1 gcntEnc=3 TEMP=300 LAMBDA=0.005 VSS=0.074 GAMMA=0.35 IOFF=0 MM=1.65 AA=1 SLOPE=10 VAA=1 RCS=1450 RCD=1450 FLG_FLD=0 RFS=1 RFD=1 RFG=1 typep=1
mn2 (VSS n0 Y) CNT_CDF_N l=0.6 w=5 MU=55 COX=150e-09 COL=0 CGSD=0 COLGSD=0 CSD=0 VTO=0.7 FLG_SPLT=1 FINGER=1 sdW=10 gsdEnc=1 gcntEnc=3 TEMP=300 LAMBDA=0.005 VSS=0.074 GAMMA=0.35 IOFF=0 MM=1.65 AA=1 SLOPE=10 VAA=1 RCS=1450 RCD=1450 FLG_FLD=0 RFS=1 RFD=1 RFG=1 typep=1
mn0 (VSS B net6) CNT_CDF_N l=0.6 w=5 MU=55 COX=150e-09 COL=0 CGSD=0 COLGSD=0 CSD=0 VTO=0.7 FLG_SPLT=1 FINGER=1 sdW=10 gsdEnc=1 gcntEnc=3 TEMP=300 LAMBDA=0.005 VSS=0.074 GAMMA=0.35 IOFF=0 MM=1.65 AA=1 SLOPE=10 VAA=1 RCS=1450 RCD=1450 FLG_FLD=0 RFS=1 RFD=1 RFG=1 typep=1
ends AND2X1
